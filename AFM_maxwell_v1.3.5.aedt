# Ansys Electronics Desktop project, version 2025.1
materials:
  vacuum: permittivity=1
  lead: permeability=0.999983 conductivity=5000000
  Cogent Power - M350-50A, B-H at 50Hz: core_loss_curve{50Hz (0, 0) (0.05, 0.01) (0.1, 0.02) (0.15, 0.055) (0.2, 0.09) (0.25, 0.135) (0.3, 0.18) (0.35, 0.24) (0.4, 0.3) (0.45, 0.37) (0.5, 0.44) (0.55, 0.515) (0.6, 0.59) (0.65, 0.675) (0.7, 0.76) (0.75, 0.855) (0.8, 0.95) (0.85, 1.055) (0.9, 1.16) (0.95, 1.275) (1, 1.39) (1.05, 1.52) (1.1, 1.65) (1.15, 1.8) (1.2, 1.95) (1.25, 2.12) (1.3, 2.29) (1.35, 2.52) (1.4, 2.75) (1.45, 3.02) (1.5, 3.29) (1.55, 3.85) (1.6, 4.41) (1.65, 4.59) (1.7, 4.77) (1.75, 4.885) (1.8, 5)} core_loss_curve{100Hz (0, 0) (0.05, 0.03) (0.1, 0.06) (0.15, 0.15) (0.2, 0.24) (0.25, 0.37) (0.3, 0.5) (0.35, 0.655) (0.4, 0.81) (0.45, 0.995) (0.5, 1.18) (0.55, 1.39) (0.6, 1.6) (0.65, 1.84) (0.7, 2.08) (0.75, 2.35) (0.8, 2.62) (0.85, 2.915) (0.9, 3.21) (0.95, 3.545) (1, 3.88) (1.05, 4.245) (1.1, 4.61) (1.15, 5.02) (1.2, 5.43) (1.25, 5.9) (1.3, 6.37) (1.35, 6.95) (1.4, 7.53) (1.45, 8.26) (1.5, 8.99) (1.55, 9.72) (1.6, 10.45) (1.65, 11.18) (1.7, 11.91) (1.75, 12.64) (1.8, 13.37)} core_loss_curve{200Hz (0, 0) (0.05, 0.085) (0.1, 0.17) (0.15, 0.395) (0.2, 0.62) (0.25, 0.96) (0.3, 1.3) (0.35, 1.725) (0.4, 2.15) (0.45, 2.66) (0.5, 3.17) (0.55, 3.765) (0.6, 4.36) (0.65, 5.045) (0.7, 5.73) (0.75, 6.52) (0.8, 7.31) (0.85, 8.2) (0.9, 9.09) (0.95, 10.095) (1, 11.1) (1.05, 12.25) (1.1, 13.4) (1.15, 14.7) (1.2, 16) (1.25, 17.45) (1.3, 18.9) (1.35, 20.6) (1.4, 22.3) (1.45, 24.45) (1.5, 26.6) (1.55, 28.75) (1.6, 30.9) (1.65, 33.05) (1.7, 35.2) (1.75, 37.35) (1.8, 39.5)} core_loss_curve{400Hz (0, 0) (0.05, 0.24) (0.1, 0.48) (0.15, 1.115) (0.2, 1.75) (0.25, 2.685) (0.3, 3.62) (0.35, 4.82) (0.4, 6.02) (0.45, 7.49) (0.5, 8.96) (0.55, 10.73) (0.6, 12.5) (0.65, 14.55) (0.7, 16.6) (0.75, 19.05) (0.8, 21.5) (0.85, 24.35) (0.9, 27.2) (0.95, 30.5) (1, 33.8) (1.05, 37.65) (1.1, 41.5) (1.15, 45.95) (1.2, 50.4) (1.25, 55.4) (1.3, 60.4) (1.35, 66.25) (1.4, 72.1) (1.45, 78.9) (1.5, 85.7) (1.55, 92.5) (1.6, 99.3) (1.65, 106.1) (1.7, 112.9) (1.75, 119.7) (1.8, 126.5)} core_loss_curve{1000Hz (0, 0) (0.05, 1.01) (0.1, 2.02) (0.15, 4.585) (0.2, 7.15) (0.25, 10.925) (0.3, 14.7) (0.35, 19.65) (0.4, 24.6) (0.45, 30.9) (0.5, 37.2) (0.55, 45.15) (0.6, 53.1) (0.65, 62.9) (0.7, 72.7) (0.75, 84.8) (0.8, 96.9) (0.85, 111.45) (0.9, 126) (0.95, 144) (1, 162) (1.05, 183) (1.1, 204) (1.15, 229) (1.2, 254) (1.25, 283) (1.3, 312) (1.35, 345) (1.4, 378) (1.45, 417) (1.5, 456) (1.55, 495) (1.6, 534) (1.65, 573) (1.7, 612) (1.75, 651) (1.8, 690)} permeability{HUnit=A_per_meter BUnit=tesla curve (0, 0) (9.03568, 0.025) (17.6854, 0.05) (25.5633, 0.075) (32.2833, 0.1) (37.5786, 0.125) (41.6583, 0.15) (44.8505, 0.175) (47.4833, 0.2) (49.8375, 0.225) (52.0042, 0.25) (54.0271, 0.275) (55.95, 0.3) (57.8115, 0.325) (59.6292, 0.35) (61.4156, 0.375) (63.1833, 0.4) (64.9438, 0.425) (66.7042, 0.45) (68.4708, 0.475) (70.25, 0.5) (72.0482, 0.525) (73.8729, 0.55) (75.732, 0.575) (77.6333, 0.6) (79.5841, 0.625) (81.5896, 0.65) (83.6544, 0.675) (85.7833, 0.7) (87.9826, 0.725) (90.2646, 0.75) (92.6435, 0.775) (95.1333, 0.8) (97.7531, 0.825) (100.542, 0.85) (103.543, 0.875) (106.8, 0.9) (110.358, 0.925) (114.267, 0.95) (118.575, 0.975) (123.333, 1) (128.602, 1.025) (134.479, 1.05) (141.076, 1.075) (148.5, 1.1) (156.909, 1.125) (166.646, 1.15) (178.102, 1.175) (191.667, 1.2) (207.922, 1.225) (228.208, 1.25) (254.057, 1.275) (287, 1.3) (329.26, 1.325) (385.833, 1.35) (462.406, 1.375) (564.667, 1.4) (698.927, 1.425) (874, 1.45) (1099.32, 1.475) (1384.33, 1.5) (1737.49, 1.525) (2163.38, 1.55) (2665.57, 1.575) (3247.67, 1.6) (3912.76, 1.625) (4661.94, 1.65) (5495.77, 1.675) (6414.83, 1.7) (7407.02, 1.72474) (8409.48, 1.74794) (9346.65, 1.76806) (10143, 1.78356) (10794.8, 1.79346) (11585.9, 1.79912) (12871.7, 1.80246) (15008, 1.80539) (18240.8, 1.80945) (22378, 1.81465) (27118.3, 1.82061) (32160, 1.82694)} conductivity=2380950 core_loss_type="Power Ferrite" core_loss_cm=24.78 core_loss_x=1.82714 core_loss_y=1.56252 mass_density=7650
  Alliance - N30UH: permeability{HUnit=A_per_meter BUnit=tesla IsTemperatureDependent Temperatures{Temperature{TempRef=25cel} Temperature{TempRef=60cel} Temperature{TempRef=100cel} Temperature{TempRef=120cel} Temperature{TempRef=150cel} Temperature{TempRef=180cel}} curve (-798000, 0) (-399000, 0.5485) (0, 1.097)} conductivity=666700 magnetic_coercivity{Magnitude=-798000A_per_meter DirComp1=0 DirComp2=0 DirComp3=1}
  Alliance - N30UH - 2: permeability{HUnit=A_per_meter BUnit=tesla IsTemperatureDependent Temperatures{Temperature{TempRef=25cel} Temperature{TempRef=60cel} Temperature{TempRef=100cel} Temperature{TempRef=120cel} Temperature{TempRef=150cel} Temperature{TempRef=180cel}} curve (-798000, 0) (-399000, 0.5485) (0, 1.097)} conductivity=666700 magnetic_coercivity{Magnitude=-798000A_per_meter DirComp1=0 DirComp2=0 DirComp3=-1}
  copper: permeability=0.999991 conductivity=58000000
  steel_1010: permittivity=1 permeability{HUnit=A_per_meter BUnit=tesla curve (0, 0) (238.7, 0.2003) (318.3, 0.3204) (358.1, 0.40045) (437.7, 0.50055) (477.5, 0.5606) (636.6, 0.7908) (795.8, 0.931) (1114.1, 1.1014) (1273.2, 1.2016) (1591.5, 1.302) (2228.2, 1.4028) (3183.1, 1.524) (4774.6, 1.626) (6366.2, 1.698) (7957.7, 1.73) (15915.5, 1.87) (31831, 1.99) (47746.5, 2.04) (63662, 2.07) (79577.5, 2.095) (159155, 2.2) (318310, 2.4)} conductivity=2000000 lande_g_factor=2
  NdFe35: permittivity=1 permeability=1.0997785 conductivity=625000 magnetic_coercivity{Magnitude=-895000A_per_meter DirComp1=0 DirComp2=0 DirComp3=1} lande_g_factor=2
  NdFe35 - negative: permittivity=1 permeability=1.0997785 conductivity=625000 magnetic_coercivity{Magnitude=-895000A_per_meter DirComp1=0 DirComp2=0 DirComp3=-1} lande_g_factor=2

design Maxwell3DDesign1 (Maxwell 3D, Transient, model units mm)
variables:
  f = 250Hz
  I_peak = 12*11.21
geometry:
  Shaft [steel_1010] = cylinder(axis=Z, base_centre=(0mm, 0mm, -70mm), radius=15mm, height=180mm)
  Air [vacuum] = cylinder(axis=Z, base_centre=(0mm, 0mm, -100mm), radius=125mm, height=250mm)
  Stator_core [steel_1010] = imported_body()
  coil [copper] = imported_body()
  coil.fillet(Edges=?.edge(at (22.1333, 11.624, 31), at (69.7766, 39.1308, 31), at (79.9937, 1, 31), at (24.98, 1, 31)) Radius=4mm Setback=0mm)
  coil_1..coil_11 [copper] = coil.duplicate_around_axis(axis=Z, angle=(360/12) deg, total=12)
  coil_12 [copper] = coil.duplicate_mirror(point=(0mm, 0mm, 20mm), normal=(0mm, 0mm, -1mm))
  coil_12_1..coil_12_11 [copper] = coil_12.duplicate_around_axis(axis=Z, angle=(360/12) deg, total=12)
  Cylinder7 = cylinder(axis=Z, base_centre=(0mm, 0mm, -0.5mm), radius=80mm, height=-90mm)
  Cylinder7_1 = Cylinder7.duplicate_mirror(point=(0mm, 0mm, 20mm), normal=(0mm, 0mm, 1mm))
  Band [vacuum] = cylinder(axis=Z, base_centre=(0mm, 0mm, -1mm), radius=16mm, height=42mm)
  Band.unite(Cylinder7_1, Cylinder7)
  current_area = rectangle(corner=(0mm, 0mm, 0mm), x_size=10mm, y_size=4mm)
  current_area.rotate(axis=Y, angle=-90deg)
  current_area.move(38mm, 1mm, 0mm)
  current_area.move(37.835348mm, 0mm, 4mm)
  current_area.move(-23.835348mm, 0mm, 0mm)
  current_area_1..current_area_11 = current_area.duplicate_around_axis(axis=Z, angle=(360/12) deg, total=12)
  current_area_12 = current_area.duplicate_mirror(point=(0mm, 0mm, 20mm), normal=(0mm, 0mm, 1mm))
  current_area_1_1 = current_area_1.duplicate_mirror(point=(0mm, 0mm, 20mm), normal=(0mm, 0mm, 1mm))
  current_area_2_1 = current_area_2.duplicate_mirror(point=(0mm, 0mm, 20mm), normal=(0mm, 0mm, 1mm))
  current_area_3_1 = current_area_3.duplicate_mirror(point=(0mm, 0mm, 20mm), normal=(0mm, 0mm, 1mm))
  current_area_4_1 = current_area_4.duplicate_mirror(point=(0mm, 0mm, 20mm), normal=(0mm, 0mm, 1mm))
  current_area_5_1 = current_area_5.duplicate_mirror(point=(0mm, 0mm, 20mm), normal=(0mm, 0mm, 1mm))
  current_area_6_1 = current_area_6.duplicate_mirror(point=(0mm, 0mm, 20mm), normal=(0mm, 0mm, 1mm))
  current_area_7_1 = current_area_7.duplicate_mirror(point=(0mm, 0mm, 20mm), normal=(0mm, 0mm, 1mm))
  current_area_8_1 = current_area_8.duplicate_mirror(point=(0mm, 0mm, 20mm), normal=(0mm, 0mm, 1mm))
  current_area_9_1 = current_area_9.duplicate_mirror(point=(0mm, 0mm, 20mm), normal=(0mm, 0mm, 1mm))
  current_area_10_1 = current_area_10.duplicate_mirror(point=(0mm, 0mm, 20mm), normal=(0mm, 0mm, 1mm))
  current_area_11_1 = current_area_11.duplicate_mirror(point=(0mm, 0mm, 20mm), normal=(0mm, 0mm, 1mm))
  Rotor_lower [steel_1010] = cylinder(axis=Z, base_centre=(0mm, 0mm, -16mm), radius=75mm, height=10mm)
  Magnet_Lower [NdFe35 - negative] = polyline(z=0mm, xy in mm: (70, 0) (67.614808, 18.117333) (60.621778, 35), AngularArc from point 0 over 3 centre=(0mm, 0mm, 0mm) angle=30deg plane=XY)
  Polyline2 = polyline(z=0mm, xy in mm: (30, 0) (28.977775, 7.7645714) (25.980762, 15), AngularArc from point 0 over 3 centre=(0mm, 0mm, 0mm) angle=30deg plane=XY)
  Polyline3 = polyline((25.980762mm, 15mm, 0mm) (60.621778mm, 35mm, 0mm))
  Polyline4 = polyline((30mm, 0mm, 0mm) (70mm, 0mm, 0mm))
  Magnet_Lower.unite(Polyline2, Polyline3, Polyline4)
  Magnet_Lower.cover_lines()
  Magnet_Lower.sweep_along_vector((0mm, 0mm, -5mm))
  Magnet_Lower.move(0mm, 0mm, -1mm)
  Magnet_Upper [NdFe35] = Magnet_Lower.duplicate_mirror(point=(0mm, 0mm, 20mm), normal=(0mm, 0mm, 1mm))
  Shaft_1 = Shaft.copy()
  Rotor_lower.subtract(Shaft_1)
  Magnet_Lower_1 [NdFe35], Magnet_Lower_2 [NdFe35 - negative], Magnet_Lower_3 [NdFe35], Magnet_Lower_4 [NdFe35 - negative], Magnet_Lower_5 [NdFe35], Magnet_Lower_6 [NdFe35 - negative], Magnet_Lower_7 [NdFe35], Magnet_Lower_8 [NdFe35 - negative], Magnet_Lower_9 [NdFe35] = Magnet_Lower.duplicate_around_axis(axis=Z, angle=(360/10) deg, total=10)
  Magnet_Upper_1 [NdFe35 - negative], Magnet_Upper_2 [NdFe35], Magnet_Upper_3 [NdFe35 - negative], Magnet_Upper_4 [NdFe35], Magnet_Upper_5 [NdFe35 - negative], Magnet_Upper_6 [NdFe35], Magnet_Upper_7 [NdFe35 - negative], Magnet_Upper_8 [NdFe35], Magnet_Upper_9 [NdFe35 - negative] = Magnet_Upper.duplicate_around_axis(axis=Z, angle=(360/10) deg, total=10)
  Magnet_Upper_3.rotate(axis=Z, angle=15deg)
  Magnet_Upper_2.rotate(axis=Z, angle=15deg)
  Magnet_Upper_1.rotate(axis=Z, angle=15deg)
  Magnet_Upper.rotate(axis=Z, angle=15deg)
  Magnet_Upper_9.rotate(axis=Z, angle=15deg)
  Magnet_Upper_4.rotate(axis=Z, angle=15deg)
  Magnet_Upper_5.rotate(axis=Z, angle=15deg)
  Magnet_Upper_6.rotate(axis=Z, angle=15deg)
  Magnet_Upper_7.rotate(axis=Z, angle=15deg)
  Magnet_Upper_8.rotate(axis=Z, angle=15deg)
  [Magnet_Upper_4, Magnet_Upper_3, Magnet_Upper_2, Magnet_Upper_1, Magnet_Upper, Magnet_Upper_9, Magnet_Upper_8, Magnet_Upper_7, Magnet_Upper_6, Magnet_Upper_5].rotate(axis=Z, angle=15deg)
  [Magnet_Upper_4, Magnet_Upper_3, Magnet_Upper_2, Magnet_Upper_1, Magnet_Upper, Magnet_Upper_9, Magnet_Upper_8, Magnet_Upper_7, Magnet_Upper_6, Magnet_Upper_5].rotate(axis=Z, angle=-30deg)
  [Magnet_Upper_4, Magnet_Upper_3, Magnet_Upper_2, Magnet_Upper_1, Magnet_Upper, Magnet_Upper_9, Magnet_Upper_8, Magnet_Upper_7, Magnet_Upper_6, Magnet_Upper_5].rotate(axis=Z, angle=20deg)
  [Magnet_Upper_4, Magnet_Upper_3, Magnet_Upper_2, Magnet_Upper_1, Magnet_Upper, Magnet_Upper_9, Magnet_Upper_8, Magnet_Upper_7, Magnet_Upper_6, Magnet_Upper_5].rotate(axis=Z, angle=25deg)
  [Magnet_Upper_4, Magnet_Upper_3, Magnet_Upper_2, Magnet_Upper_1, Magnet_Upper, Magnet_Upper_9, Magnet_Upper_8, Magnet_Upper_7, Magnet_Upper_6, Magnet_Upper_5].rotate(axis=Z, angle=-20deg)
  [Magnet_Upper_4, Magnet_Upper_3, Magnet_Upper_2, Magnet_Upper_1, Magnet_Upper, Magnet_Upper_9, Magnet_Upper_8, Magnet_Upper_7, Magnet_Upper_6, Magnet_Upper_5].rotate(axis=Z, angle=-5deg)
  [Magnet_Lower_7, Magnet_Lower_8, Magnet_Lower_9, Magnet_Lower, Magnet_Lower_6, Magnet_Lower_5, Magnet_Lower_4, Magnet_Lower_3, Magnet_Lower_2, Magnet_Lower_1].rotate(axis=Z, angle=20deg)
  Magnet_Upper_2.rotate(axis=Z, angle=-20deg)
  Magnet_Upper_1.rotate(axis=Z, angle=-20deg)
  Magnet_Upper.rotate(axis=Z, angle=-20deg)
  Magnet_Upper_9.rotate(axis=Z, angle=-20deg)
  Magnet_Upper_8.rotate(axis=Z, angle=-20deg)
  Magnet_Upper_7.rotate(axis=Z, angle=-20deg)
  Magnet_Upper_6.rotate(axis=Z, angle=-20deg)
  Magnet_Upper_5.rotate(axis=Z, angle=-20deg)
  Magnet_Upper_4.rotate(axis=Z, angle=-20deg)
  Magnet_Upper_3.rotate(axis=Z, angle=-20deg)
  [Magnet_Upper, Magnet_Upper_1..Magnet_Upper_9].rotate(axis=Z, angle=-20deg)
  [Magnet_Upper, Magnet_Upper_1..Magnet_Upper_9].rotate(axis=Z, angle=5deg)
  [Magnet_Upper, Magnet_Upper_1..Magnet_Upper_9].rotate(axis=Z, angle=-1deg)
  [Magnet_Upper, Magnet_Upper_1..Magnet_Upper_9].rotate(axis=Z, angle=35deg)
  [Magnet_Upper, Magnet_Upper_1..Magnet_Upper_9].rotate(axis=Z, angle=1deg)
  [Magnet_Upper, Magnet_Upper_1..Magnet_Upper_9].rotate(axis=Z, angle=18deg)
  [Magnet_Upper, Magnet_Upper_1..Magnet_Upper_9].rotate(axis=Z, angle=36deg)
  [Magnet_Upper, Magnet_Upper_1..Magnet_Upper_9].rotate(axis=Z, angle=-18deg)
  [Magnet_Upper, Magnet_Upper_1..Magnet_Upper_9].rotate(axis=Z, angle=72deg)
  [Magnet_Upper, Magnet_Upper_1..Magnet_Upper_9].rotate(axis=Z, angle=36deg)
  [Magnet_Upper, Magnet_Upper_1..Magnet_Upper_9].rotate(axis=Z, angle=-36deg)
  Rotor_upper [steel_1010] = Rotor_lower.duplicate_mirror(point=(0mm, 0mm, 20mm), normal=(0mm, 0mm, 1mm))
  group coil_Group_up = coil, coil_1..coil_11
  group coil_Group_lower = coil_12, coil_12_1..coil_12_11
  group Magnet_Lower_Group = Magnet_Lower, Magnet_Lower_1..Magnet_Lower_9
  group Magnet_Upper_Group = Magnet_Upper, Magnet_Upper_1..Magnet_Upper_9
motion:
  MotionSetup1: Band Move_Type=Rotate Coordinate_System=Global Axis=Z Is_Positive=true InitPos=0deg Angular_Velocity=3000rpm Objects=Band
  Moving1: Moving Objects=[Magnet_Lower, Magnet_Upper, Magnet_Lower_1..Magnet_Lower_9, Magnet_Upper_1..Magnet_Upper_9, Shaft, Rotor_lower, Rotor_upper]
boundaries and excitations:
  A1_D1: Coil Terminal Objects=current_area Conductor_number=1 Winding=A Point_out_of_terminal=true
  A1_D2: Coil Terminal Objects=current_area_1 Conductor_number=1 Winding=A Point_out_of_terminal=false
  B1_D1: Coil Terminal Objects=current_area_2 Conductor_number=1 Winding=B Point_out_of_terminal=false
  B1_D2: Coil Terminal Objects=current_area_3 Conductor_number=1 Winding=B Point_out_of_terminal=true
  C1_D1: Coil Terminal Objects=current_area_4 Conductor_number=1 Winding=C Point_out_of_terminal=true
  C1_D2: Coil Terminal Objects=current_area_5 Conductor_number=1 Winding=C Point_out_of_terminal=false
  A1_D1_dash: Coil Terminal Objects=current_area_6 Conductor_number=1 Winding=A Point_out_of_terminal=false
  A1_D2_dash: Coil Terminal Objects=current_area_7 Conductor_number=1 Winding=A Point_out_of_terminal=true
  B1_D1_dash: Coil Terminal Objects=current_area_8 Conductor_number=1 Winding=B Point_out_of_terminal=true
  B1_D2_dash: Coil Terminal Objects=current_area_9 Conductor_number=1 Winding=B Point_out_of_terminal=false
  C1_D1_dash: Coil Terminal Objects=current_area_10 Conductor_number=1 Winding=C Point_out_of_terminal=false
  C1_D2_dash: Coil Terminal Objects=current_area_11 Conductor_number=1 Winding=C Point_out_of_terminal=true
  A1_U1: Coil Terminal Objects=current_area_12 Conductor_number=1 Winding=A Point_out_of_terminal=true
  A1_U2: Coil Terminal Objects=current_area_1_1 Conductor_number=1 Winding=A Point_out_of_terminal=false
  B1_U1: Coil Terminal Objects=current_area_2_1 Conductor_number=1 Winding=B Point_out_of_terminal=false
  B1_U2: Coil Terminal Objects=current_area_3_1 Conductor_number=1 Winding=B Point_out_of_terminal=true
  C1_U1: Coil Terminal Objects=current_area_4_1 Conductor_number=1 Winding=C Point_out_of_terminal=true
  C1_U2: Coil Terminal Objects=current_area_5_1 Conductor_number=1 Winding=C Point_out_of_terminal=false
  A1_U1_dash: Coil Terminal Objects=current_area_6_1 Conductor_number=1 Winding=A Point_out_of_terminal=false
  A1_U2_dash: Coil Terminal Objects=current_area_7_1 Conductor_number=1 Winding=A Point_out_of_terminal=true
  B1_U1_dash: Coil Terminal Objects=current_area_8_1 Conductor_number=1 Winding=B Point_out_of_terminal=true
  B1_U2_dash: Coil Terminal Objects=current_area_9_1 Conductor_number=1 Winding=B Point_out_of_terminal=false
  C1_U1_dash: Coil Terminal Objects=current_area_10_1 Conductor_number=1 Winding=C Point_out_of_terminal=false
  C1_U2_dash: Coil Terminal Objects=current_area_11_1 Conductor_number=1 Winding=C Point_out_of_terminal=true
  A: Winding Group Type=Current IsSolid=true Current=I_peak*sin(2*pi*f*time) ParallelBranchesNum=1
  B: Winding Group Type=Current IsSolid=true Current=I_peak*sin(2*pi*f*time-120deg) ParallelBranchesNum=1
  C: Winding Group Type=Current IsSolid=true Current=I_peak*sin(2*pi*f*time+120deg) ParallelBranchesNum=1
parameters:
  Torque1: Torque Is_Virtual=true Coordinate_System=Global Axis=Z Is_Positive=true Objects=[Shaft, Rotor_lower, Magnet_Lower, Magnet_Upper, Magnet_Lower_1..Magnet_Lower_9, Magnet_Upper_1..Magnet_Upper_9, Rotor_upper]
mesh:
  CylindricalGap1: CylindricalGap Objects=Band BandMappingAngle=3deg MovingSideLayers=1 StaticSideLayers=1 Objects=Band
  initial mesh: GlobalCurvilinear{Apply}
setups:
  Setup1: Transient NonlinearSolverResidual=0.005 ScalarPotential="Second Order" StopTime=20s TimeStep=0.2s SaveFieldsType="Every N Steps" N_Steps=1 Steps_From=0s Steps_To=20s NumberSolveSteps=1 RangeStart=0s RangeEnd=0.1s
